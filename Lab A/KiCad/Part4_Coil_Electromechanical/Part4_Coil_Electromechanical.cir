.title KiCad schematic
.ac dec 200 1 10k
R2 /u_c /u_1 1
L2 /u_c /u_1 10u
C2 /u_1 GND 0.1
L3 /u_1 GND 0.01
R3 /u_1 GND 10
V1 /e_in GND DC 0 AC 1
G1 GND /u_c /e_a /e_b 3
E1 /e_c GND /u_c GND 1.5
C1 /u_c GND 0.005
R1 /e_a /e_b 0.5
Vs1 /e_in /e_a DC 0
L1 /e_b /e_c 10u
.end
