* batch driver for Part2b_Silencer_VolumeVelocitySource.cir
.include Part2b_Silencer_VolumeVelocitySource.cir
.control
run

set wr_vecnames
set wr_singlescale
wrdata Part2b_Silencer_VolumeVelocitySource_ac.txt i(vs1) i(vs3) i(vs5) i(vs7) v(/p2) v(/p4) v(/p6)
quit
.endc
.end
